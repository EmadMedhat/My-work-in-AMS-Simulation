ADE simulation setup
Run mode: Single Run, Sweeps and Corners
Tests:
  PLL_SIEMENS:divider_tb:2: PLL_SIEMENS/divider_tb/schematic, simulator spectre
Global variables:
  LN = 180n
  LP = 180n
  WN = 1u
  WP = 2u
