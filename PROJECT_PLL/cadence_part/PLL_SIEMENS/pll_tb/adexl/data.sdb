ADE simulation setup
Run mode: Single Run, Sweeps and Corners
Tests:
  PLL_SIEMENS:pll_tb:1: PLL_SIEMENS/pll_tb/config, simulator spectre
Global variables:
  LN = 180n
  LP = 180n
  WN = 1u
  WP = 2u
