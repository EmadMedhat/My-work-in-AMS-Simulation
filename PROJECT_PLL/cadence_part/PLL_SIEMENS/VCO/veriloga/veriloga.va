// AMS PLL Project: Voltage Controlled Oscillator (VCO)

`include "constants.vams"
`include "disciplines.vams"

module VCO(VCTRL,VOUT);

	parameter real VHIGH = 1.2;
	parameter real Vmin=0.2;
	parameter real Vmax=1 from (Vmin:inf);
	parameter real Fmin=0.5G from (0:inf);
	parameter real Fmax=1.5G from (Fmin:inf);
	parameter real trise=10p, tfall=10p, td=0;

	input VCTRL;
	output VOUT;
	voltage VCTRL,VOUT;

	real freq,phase,sine,VOUT_i;

	analog begin

		// compute the freq from the input voltage
		freq =((V(VCTRL) - Vmin)*2.1*1e9) + Fmin;
		// bound the frequency
		if (freq > Fmax) freq = Fmax;
		if (freq < Fmin) freq = Fmin;

		// calculate the phase (modulo 2*pi)
		phase=2*`M_PI*idtmod(freq,0.0,1.0,-0.5);

		// generate the output
		sine = sin(phase);

		@(cross(sine,0))
			;

		if (sine > 0)
			VOUT_i=VHIGH;
		else
			VOUT_i=0;

		V(VOUT) <+ transition(VOUT_i,td,trise,tfall);

		// bound the time step
		$bound_step(0.1/freq);

	end
endmodule
